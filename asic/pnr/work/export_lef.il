cv = dbOpenCellViewByType("2025_APP" "0814_opamp_N_P" "abstract" "" "r")
leWriteLEF(cv "myCell.lef")
dbClose(cv)
